* NGSPICE file created from dff_final.ext - technology: sky130A

.subckt dff_final D CLK VDD GND Q
X0 a_4539_14# a_5170_20# GND GND sky130_fd_pr__nfet_01v8 ad=0.126 pd=1.44 as=0.126 ps=1.44 w=0.42 l=0.15
X1 a_815_14# a_n473_32# a_215_32# GND sky130_fd_pr__nfet_01v8 ad=0.126 pd=1.44 as=0.126 ps=1.44 w=0.42 l=0.15
X2 a_4539_14# a_5170_20# VDD VDD sky130_fd_pr__pfet_01v8 ad=0.378 pd=3.12 as=0.378 ps=3.12 w=1.26 l=0.15
X3 a_3570_20# CLK a_2259_32# GND sky130_fd_pr__nfet_01v8 ad=0.165 pd=1.7 as=0.165 ps=1.7 w=0.55 l=0.15
X4 a_2259_32# a_815_14# VDD VDD sky130_fd_pr__pfet_01v8 ad=0.378 pd=3.12 as=0.378 ps=3.12 w=1.26 l=0.15
X5 VDD a_5170_20# Q VDD sky130_fd_pr__pfet_01v8 ad=0.39 pd=3.2 as=0.195 ps=1.6 w=1.3 l=0.15
X6 a_215_32# D GND GND sky130_fd_pr__nfet_01v8 ad=0.126 pd=1.44 as=0.126 ps=1.44 w=0.42 l=0.15
X7 Q a_5170_20# VDD VDD sky130_fd_pr__pfet_01v8 ad=0.195 pd=1.6 as=0.39 ps=3.2 w=1.3 l=0.15
X8 a_4539_14# CLK a_3570_20# VDD sky130_fd_pr__pfet_01v8 ad=0.378 pd=3.12 as=0.378 ps=3.12 w=1.26 l=0.15
X9 a_215_32# D VDD VDD sky130_fd_pr__pfet_01v8 ad=0.378 pd=3.12 as=0.378 ps=3.12 w=1.26 l=0.15
X10 a_1607_14# a_2259_32# GND GND sky130_fd_pr__nfet_01v8 ad=0.126 pd=1.44 as=0.126 ps=1.44 w=0.42 l=0.15
X11 a_4539_14# a_n473_32# a_3570_20# GND sky130_fd_pr__nfet_01v8 ad=0.126 pd=1.44 as=0.126 ps=1.44 w=0.42 l=0.15
X12 a_n473_32# CLK GND GND sky130_fd_pr__nfet_01v8 ad=0.126 pd=1.44 as=0.126 ps=1.44 w=0.42 l=0.15
X13 a_2259_32# a_n473_32# a_3570_20# VDD sky130_fd_pr__pfet_01v8 ad=0.2475 pd=2.25 as=0.12375 ps=1.125 w=0.825 l=0.15
X14 a_5170_20# a_3570_20# GND GND sky130_fd_pr__nfet_01v8 ad=0.18 pd=1.8 as=0.18 ps=1.8 w=0.6 l=0.15
X15 a_3570_20# a_n473_32# a_2259_32# VDD sky130_fd_pr__pfet_01v8 ad=0.12375 pd=1.125 as=0.2475 ps=2.25 w=0.825 l=0.15
X16 VDD a_3570_20# a_5170_20# VDD sky130_fd_pr__pfet_01v8 ad=0.27 pd=2.4 as=0.135 ps=1.2 w=0.9 l=0.15
X17 a_815_14# CLK a_215_32# VDD sky130_fd_pr__pfet_01v8 ad=0.378 pd=3.12 as=0.378 ps=3.12 w=1.26 l=0.15
X18 a_5170_20# a_3570_20# VDD VDD sky130_fd_pr__pfet_01v8 ad=0.135 pd=1.2 as=0.27 ps=2.4 w=0.9 l=0.15
X19 a_1607_14# CLK a_815_14# GND sky130_fd_pr__nfet_01v8 ad=0.126 pd=1.44 as=0.126 ps=1.44 w=0.42 l=0.15
X20 Q a_5170_20# GND GND sky130_fd_pr__nfet_01v8 ad=0.21 pd=2 as=0.21 ps=2 w=0.7 l=0.15
X21 a_n473_32# CLK VDD VDD sky130_fd_pr__pfet_01v8 ad=0.378 pd=3.12 as=0.378 ps=3.12 w=1.26 l=0.15
X22 a_1607_14# a_2259_32# VDD VDD sky130_fd_pr__pfet_01v8 ad=0.378 pd=3.12 as=0.378 ps=3.12 w=1.26 l=0.15
X23 a_2259_32# a_815_14# GND GND sky130_fd_pr__nfet_01v8 ad=0.126 pd=1.44 as=0.126 ps=1.44 w=0.42 l=0.15
X24 a_1607_14# a_n473_32# a_815_14# VDD sky130_fd_pr__pfet_01v8 ad=0.378 pd=3.12 as=0.378 ps=3.12 w=1.26 l=0.15
C0 CLK a_n473_32# 1.09495f
C1 a_2259_32# a_n473_32# 0.54114f
C2 a_815_14# a_215_32# 0.22651f
C3 VDD a_n473_32# 1.4889f
C4 CLK a_1607_14# 0.69295f
C5 a_2259_32# a_1607_14# 0.51727f
C6 VDD a_1607_14# 0.3632f
C7 D a_215_32# 0.03569f
C8 a_815_14# CLK 0.24388f
C9 a_815_14# a_2259_32# 0.05118f
C10 Q a_4539_14# 0.00661f
C11 a_n473_32# a_1607_14# 0.21409f
C12 a_3570_20# CLK 0.50311f
C13 a_3570_20# a_2259_32# 0.2484f
C14 a_815_14# VDD 0.45544f
C15 a_3570_20# VDD 0.25427f
C16 CLK a_5170_20# 0
C17 a_2259_32# a_5170_20# 0
C18 D CLK 0.04667f
C19 VDD a_5170_20# 0.51433f
C20 D VDD 0.0836f
C21 a_815_14# a_n473_32# 0.30325f
C22 a_3570_20# a_n473_32# 0.33486f
C23 a_815_14# a_1607_14# 0.39175f
C24 a_n473_32# a_5170_20# 0
C25 a_3570_20# a_1607_14# 0
C26 D a_n473_32# 0.02307f
C27 D a_1607_14# 0
C28 a_4539_14# CLK 0.0126f
C29 a_2259_32# a_4539_14# 0
C30 VDD a_4539_14# 0.41414f
C31 a_3570_20# a_815_14# 0
C32 VDD Q 0.05439f
C33 D a_815_14# 0
C34 a_3570_20# a_5170_20# 0.06923f
C35 a_4539_14# a_n473_32# 0.02648f
C36 CLK a_215_32# 0.1171f
C37 a_4539_14# a_1607_14# 0
C38 VDD a_215_32# 0.31099f
C39 a_n473_32# a_215_32# 0.2019f
C40 a_2259_32# CLK 0.19784f
C41 a_3570_20# a_4539_14# 0.446f
C42 VDD CLK 0.44974f
C43 VDD a_2259_32# 0.79268f
C44 a_1607_14# a_215_32# 0
C45 a_3570_20# Q 0
C46 a_4539_14# a_5170_20# 0.48809f
C47 Q a_5170_20# 0.05307f
C48 Q GND 0.98341f
C49 VDD GND 7.31391f
C50 a_4539_14# GND 1.98923f
C51 a_1607_14# GND 2.76113f
C52 a_215_32# GND 2.00874f
.ends
