* NGSPICE file created from dff_final.ext - technology: sky130A

.subckt dff_final gnd vdd CLK D Q
X0 a_3215_200# a_2415_200# vdd vdd sky130_fd_pr__pfet_01v8 ad=0.5775 pd=3.25 as=0.5775 ps=3.25 w=1.1 l=0.15
X1 D_uq0 D vdd vdd sky130_fd_pr__pfet_01v8 ad=0.5775 pd=3.25 as=0.5775 ps=3.25 w=1.1 l=0.15
X2 a_7215_200# a_6415_200# vdd vdd sky130_fd_pr__pfet_01v8 ad=0.5775 pd=3.25 as=0.5775 ps=3.25 w=1.1 l=0.15
X3 a_815_200# CLK gnd gnd sky130_fd_pr__nfet_01v8 ad=0.2205 pd=1.89 as=0.2205 ps=1.89 w=0.42 l=0.15
X4 a_4015_200# a_3215_200# gnd gnd sky130_fd_pr__nfet_01v8 ad=0.2205 pd=1.89 as=0.2205 ps=1.89 w=0.42 l=0.15
X5 a_2415_200# a_815_200# D_uq0 gnd sky130_fd_pr__nfet_01v8 ad=0.2205 pd=1.89 as=0.2205 ps=1.89 w=0.42 l=0.15
X6 a_5615_200# a_815_200# a_7215_200# gnd sky130_fd_pr__nfet_01v8 ad=0.2205 pd=1.89 as=0.2205 ps=1.89 w=0.42 l=0.15
X7 a_6415_200# a_5615_200# gnd gnd sky130_fd_pr__nfet_01v8 ad=0.2205 pd=1.89 as=0.2205 ps=1.89 w=0.42 l=0.15
X8 a_1615_200# a_815_200# vdd vdd sky130_fd_pr__pfet_01v8 ad=0.5775 pd=3.25 as=0.5775 ps=3.25 w=1.1 l=0.15
X9 a_5615_200# a_815_200# a_3215_200# vdd sky130_fd_pr__pfet_01v8 ad=0.5775 pd=3.25 as=0.5775 ps=3.25 w=1.1 l=0.15
X10 Q a_6415_200# vdd vdd sky130_fd_pr__pfet_01v8 ad=0.777 pd=4.01 as=0.777 ps=4.01 w=1.48 l=0.15
X11 a_2415_200# a_1615_200# a_4015_200# gnd sky130_fd_pr__nfet_01v8 ad=0.2205 pd=1.89 as=0.2205 ps=1.89 w=0.42 l=0.15
X12 D_uq0 D gnd gnd sky130_fd_pr__nfet_01v8 ad=0.2205 pd=1.89 as=0.2205 ps=1.89 w=0.42 l=0.15
X13 a_3215_200# a_2415_200# gnd gnd sky130_fd_pr__nfet_01v8 ad=0.2205 pd=1.89 as=0.2205 ps=1.89 w=0.42 l=0.15
X14 a_7215_200# a_6415_200# gnd gnd sky130_fd_pr__nfet_01v8 ad=0.2205 pd=1.89 as=0.2205 ps=1.89 w=0.42 l=0.15
X15 a_815_200# CLK vdd vdd sky130_fd_pr__pfet_01v8 ad=0.5775 pd=3.25 as=0.5775 ps=3.25 w=1.1 l=0.15
X16 a_4015_200# a_3215_200# vdd vdd sky130_fd_pr__pfet_01v8 ad=0.5775 pd=3.25 as=0.5775 ps=3.25 w=1.1 l=0.15
X17 a_5615_200# a_1615_200# a_7215_200# vdd sky130_fd_pr__pfet_01v8 ad=0.5775 pd=3.25 as=0.5775 ps=3.25 w=1.1 l=0.15
X18 a_2415_200# a_1615_200# D_uq0 vdd sky130_fd_pr__pfet_01v8 ad=0.5775 pd=3.25 as=0.5775 ps=3.25 w=1.1 l=0.15
X19 a_6415_200# a_5615_200# vdd vdd sky130_fd_pr__pfet_01v8 ad=0.5775 pd=3.25 as=0.5775 ps=3.25 w=1.1 l=0.15
X20 a_1615_200# a_815_200# gnd gnd sky130_fd_pr__nfet_01v8 ad=0.2205 pd=1.89 as=0.2205 ps=1.89 w=0.42 l=0.15
X21 a_5615_200# a_1615_200# a_3215_200# gnd sky130_fd_pr__nfet_01v8 ad=0.2205 pd=1.89 as=0.2205 ps=1.89 w=0.42 l=0.15
X22 Q a_6415_200# gnd gnd sky130_fd_pr__nfet_01v8 ad=0.24675 pd=1.99 as=0.24675 ps=1.99 w=0.47 l=0.15
X23 a_2415_200# a_815_200# a_4015_200# vdd sky130_fd_pr__pfet_01v8 ad=0.5775 pd=3.25 as=0.5775 ps=3.25 w=1.1 l=0.15
C0 CLK vdd 0.13776f
C1 a_6415_200# vdd 0.5354f
C2 a_6415_200# a_5615_200# 0.1974f
C3 a_5615_200# vdd 0.96314f
C4 D_uq0 a_815_200# 0.01989f
C5 a_4015_200# a_815_200# 0.01288f
C6 a_3215_200# a_815_200# 0.01569f
C7 D_uq0 a_1615_200# 0.04668f
C8 a_815_200# D 0.0017f
C9 a_7215_200# a_815_200# 0.00856f
C10 a_2415_200# a_815_200# 0.03192f
C11 a_4015_200# a_1615_200# 0.00879f
C12 a_815_200# CLK 0.076f
C13 a_6415_200# a_815_200# 0.00699f
C14 a_815_200# vdd 1.19166f
C15 a_5615_200# a_815_200# 0.02185f
C16 a_3215_200# a_1615_200# 0.01969f
C17 D_uq0 Q 0.01231f
C18 a_1615_200# D 0.00166f
C19 a_4015_200# D_uq0 0.15409f
C20 a_7215_200# a_1615_200# 0.01137f
C21 a_2415_200# a_1615_200# 0.02345f
C22 a_3215_200# D_uq0 0.73535f
C23 a_6415_200# a_1615_200# 0.00388f
C24 a_1615_200# vdd 3.01258f
C25 D_uq0 D 0.07646f
C26 a_1615_200# a_5615_200# 0.02651f
C27 D_uq0 a_7215_200# 0.10825f
C28 a_2415_200# D_uq0 1.7037f
C29 Q D 0
C30 a_3215_200# a_4015_200# 0.22155f
C31 D_uq0 CLK 0
C32 a_2415_200# a_4015_200# 0.24575f
C33 a_6415_200# D_uq0 1.53419f
C34 D_uq0 vdd 0.72513f
C35 D_uq0 a_5615_200# 1.56952f
C36 a_6415_200# Q 0.04492f
C37 Q vdd 0.11598f
C38 a_5615_200# Q 0
C39 a_3215_200# a_2415_200# 0.2241f
C40 a_4015_200# vdd 0.23043f
C41 a_7215_200# D 0
C42 a_4015_200# a_5615_200# 0
C43 a_3215_200# a_6415_200# 0
C44 a_3215_200# vdd 0.35624f
C45 a_3215_200# a_5615_200# 0.13753f
C46 a_6415_200# D 0.07319f
C47 D vdd 0.13557f
C48 a_6415_200# a_7215_200# 0.2303f
C49 a_5615_200# D 0.01412f
C50 a_7215_200# vdd 0.23067f
C51 a_6415_200# a_2415_200# 0
C52 a_2415_200# vdd 0.95772f
C53 a_1615_200# a_815_200# 3.67212f
C54 a_7215_200# a_5615_200# 0.24575f
C55 a_2415_200# a_5615_200# 0.00406f
C56 Q gnd 0.33984f
C57 vdd gnd 24.54661f
C58 a_7215_200# gnd 1.26042f
C59 a_4015_200# gnd 4.55146f
C60 D_uq0 gnd 4.72526f
.ends
